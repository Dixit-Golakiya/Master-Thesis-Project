* C:\Users\dixit\Downloads\LTspice\LTspice\Charging_Discharging\test1.asc
* Generated by LTspice 26.0.1 for Windows.
V1 3V3 0 3.3
V3 DAC 0 PULSE(0 3.3 25 1e-9 1e-9 10 10 1)
X§U2 N009 N007 5V 0 N006 TLV354 ;§pnba IN+)IN-)VCC)VEE)OUT
V4 5V 0 5
X§U3 CS- N005 5V 0 N004 TLV354 ;§pnba IN+)IN-)VCC)VEE)OUT
C3 V3 V4 25 Rser=0.034
C4 V4 V5 25 Rser=0.034
C5 V5 V6 25 Rser=0.034
C6 V6 V7 25 Rser=0.034
C7 V7 V8 25 Rser=0.034
C8 V8 V9 25 Rser=0.034
C9 V1 V2 25 Rser=0.034
C10 V2 V3 25 Rser=0.034
C11 V3 V4 25 Rser=0.034
C12 V4 V5 25 Rser=0.034
C13 V5 V6 25 Rser=0.034
C14 V6 V7 25 Rser=0.034
C15 V7 V8 25 Rser=0.034
C16 V8 V9 25 Rser=0.034
C17 V1 V2 25 Rser=0.034
C18 V2 V3 25 Rser=0.034
C19 V3 V4 25 Rser=0.034
C20 V4 V5 25 Rser=0.034
C21 V5 V6 25 Rser=0.034
C22 V6 V7 25 Rser=0.034
C23 V7 V8 25 Rser=0.034
C24 V8 V9 25 Rser=0.034
C25 V1 V2 25 Rser=0.034
C26 V2 V3 25 Rser=0.034
C27 V3 V4 25 Rser=0.034
C28 V4 V5 25 Rser=0.034
C29 V5 V6 25 Rser=0.034
C30 V6 V7 25 Rser=0.034
C31 V7 V8 25 Rser=0.034
C32 V8 V9 25 Rser=0.034
C1 V1 V2 25 Rser=0.034
C2 V2 V3 25 Rser=0.034
X§U1 CS+ N008 CS- irl540ns ;§pnba 1)2)3
I1 0 CS+ PULSE(0 2 0 1e-6 1e-6 16 16 1)
R1 V1 V2 470 tol=1
R2 V2 V3 470 tol=1
R3 V3 V4 470 tol=1
R4 V4 V5 470 tol=1
R5 V5 V6 470 tol=1
R6 V6 V7 470 tol=1
R7 V7 V8 470 tol=1
R8 V8 V9 470 tol=1
R9 V9 0 0.033 tol=1
R10 CS- 0 0.033 tol=1
R11 N006 N008 100 tol=1
R12 0 N009 3k tol=1
R13 DAC N009 12k tol=1
R14 N004 N007 470 tol=1
R15 N005 N004 9k tol=1
R16 N005 0 1k tol=1
X§U6 0 0 3V3 0 N003 3V3 0 CS- INA241A2 ;§pnba INN)GND1)REF2)GND2)OUT)VCC)REF1)INP
X§U5 0 0 3V3 0 N002 3V3 0 V9 INA241A2 ;§pnba INN)GND1)REF2)GND2)OUT)VCC)REF1)INP
B1 0 0 I=(V(i1)-1.64979)/0.2
B2 0 0 I=(V(i2)-1.64979)/(20*0.033)
B3 0 0 I=(V(i3)-1.64979)/(20*0.033)
R18 I2 N002 160 tol=1
R19 I3 N003 160 tol=1
X§U4 CS+ V1 3V3 0 N001 TMCS1108A3B MODE=1 ;§pnba IN+)IN-)VS)GND)OUT
C33 V1 V2 25 Rser=0.034
C34 V2 V3 25 Rser=0.034
C35 V3 V4 25 Rser=0.034
C36 V4 V5 25 Rser=0.034
C37 V5 V6 25 Rser=0.034
C38 V6 V7 25 Rser=0.034
C39 V7 V8 25 Rser=0.034
C40 V8 V9 25 Rser=0.034
C41 N008 CS- 100n
C42 N007 N006 100n
C43 I1 0 100n
C44 I2 0 100n
C45 I3 0 100n
R20 V01 V1 525k
R21 0 V01 75k
R22 V02 V2 450k
R23 0 V02 75k
R24 V03 V3 375k
R25 0 V03 75k
R26 V04 V4 300k
R27 0 V04 75k
R28 V05 V5 225k
R29 0 V05 75k
R30 V06 V6 150k
R31 0 V06 75k
R32 V07 V7 75k
R33 0 V07 75k
R17 I1 N001 160 tol=1
.tran 0 40 17
.ic V(V1)=18.0128
.options abstol=1n reltol=0.01 vntol=1m noopiter
* Current Sink
* Power Supply
* Current Measurement
* Capacitor Bank
* Voltage Divider
* Library below included based on ModelFile attribute of instance X§U1 (C:\Users\dixit\Downloads\LTspice\LTspice\Charging_Discharging\irl540ns.asy)
.lib irl540ns.spi
* Library below included based on ModelFile attribute of instance X§U2, X§U3 (C:\Users\dixit\Downloads\LTspice\LTspice\Charging_Discharging\TLV354.asy)
.lib TLV354.LIB
* Library below included based on ModelFile attribute of instance X§U6, X§U5 (C:\Users\dixit\Downloads\LTspice\LTspice\Charging_Discharging\INA241A2.asy)
.lib 241.lib
* Library below included based on ModelFile attribute of instance X§U4 (C:\Users\dixit\Downloads\LTspice\LTspice\Charging_Discharging\TMCS1108A3B.asy)
.lib TMCS1108A3B.lib
.backanno
.end
